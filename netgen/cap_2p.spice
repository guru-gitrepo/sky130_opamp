** sch_path: /home/guru/Projects/sky130_opamp/xschem/opamp/cap_2p.sch
.subckt cap_2p B A
*.PININFO B:B A:B
XC2 A B sky130_fd_pr__cap_mim_m3_1 W=10 L=10 MF=10 m=10
.ends
