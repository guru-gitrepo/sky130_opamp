** sch_path: /home/guru/Projects/sky130_opamp/xschem/opamp/sim_opamp_stb.sch
**.subckt sim_opamp_stb
x1 vdd vss vout net1 net2 ib en opamp
V1 vdd 0 {vvdd}
V2 vss 0 0
V3 en 0 {vvdd}
V4 vp 0 {vvdd/2}
I0 ib 0 5u
CL vout 0 10p
R1 vout net2 1G
C1 net2 0 100
V5 net1 vp ac=1
**** begin user architecture code

.include opamp_stb_tt.sp
*.include opamp_stb_ss.sp
*.include opamp_stb_ff.sp
*.include opamp_stb_sf.sp
*.include opamp_stb_fs.sp

**** end user architecture code
**.ends

* expanding   symbol:  opamp.sym # of pins=7
** sym_path: /home/guru/Projects/sky130_opamp/xschem/opamp/opamp.sym
** sch_path: /home/guru/Projects/sky130_opamp/xschem/opamp/opamp.sch
.subckt opamp vdd vss vout vp vm ib_5ua en
*.ipin vdd
*.ipin vss
*.ipin vm
*.ipin vp
*.ipin ib_5ua
*.opin vout
*.ipin en
XM1 net2 vm net1 vdd sky130_fd_pr__pfet_01v8_lvt L=0.5 W=25 nf=5 ad=4.35 as=4.35 pd=31.74 ps=31.74 nrd=0.0116 nrs=0.0116 sa=0 sb=0
+ sd=0 mult=1
XM2 net3 vp net1 vdd sky130_fd_pr__pfet_01v8_lvt L=0.5 W=25 nf=5 ad=4.35 as=4.35 pd=31.74 ps=31.74 nrd=0.0116 nrs=0.0116 sa=0 sb=0
+ sd=0 mult=1
XM3 net2 net2 vss vss sky130_fd_pr__nfet_01v8_lvt L=1 W=0.7 nf=1 ad=0.203 as=0.203 pd=1.98 ps=1.98 nrd=0.414285714285714
+ nrs=0.414285714285714 sa=0 sb=0 sd=0 mult=1
XM4 net3 net2 vss vss sky130_fd_pr__nfet_01v8_lvt L=1 W=0.7 nf=1 ad=0.203 as=0.203 pd=1.98 ps=1.98 nrd=0.414285714285714
+ nrs=0.414285714285714 sa=0 sb=0 sd=0 mult=1
XM5 net1 net4 vdd vdd sky130_fd_pr__pfet_01v8_lvt L=1 W=12 nf=2 ad=1.74 as=3.48 pd=12.58 ps=25.16 nrd=0.0241666666666667
+ nrs=0.0241666666666667 sa=0 sb=0 sd=0 mult=1
XM6 vout net3 vss vss sky130_fd_pr__nfet_01v8_lvt L=0.6 W=10 nf=2 ad=1.45 as=2.9 pd=10.58 ps=21.16 nrd=0.029 nrs=0.029 sa=0 sb=0
+ sd=0 mult=1
XM7 vout net4 vdd vdd sky130_fd_pr__pfet_01v8_lvt L=1 W=72 nf=12 ad=10.44 as=12.18 pd=75.48 ps=88.06 nrd=0.00402777777777778
+ nrs=0.00402777777777778 sa=0 sb=0 sd=0 mult=1
XM8 net4 net4 vdd vdd sky130_fd_pr__pfet_01v8_lvt L=1 W=6 nf=1 ad=1.74 as=1.74 pd=12.58 ps=12.58 nrd=0.0483333333333333
+ nrs=0.0483333333333333 sa=0 sb=0 sd=0 mult=1
XM9 net4 en vdd vdd sky130_fd_pr__pfet_01v8_lvt L=1 W=1 nf=1 ad=0.29 as=0.29 pd=2.58 ps=2.58 nrd=0.29 nrs=0.29 sa=0 sb=0 sd=0
+ mult=1
XM10 net2 enb vss vss sky130_fd_pr__nfet_01v8_lvt L=1 W=1 nf=1 ad=0.29 as=0.29 pd=2.58 ps=2.58 nrd=0.29 nrs=0.29 sa=0 sb=0 sd=0
+ mult=1
XM11 net3 enb vss vss sky130_fd_pr__nfet_01v8_lvt L=1 W=1 nf=1 ad=0.29 as=0.29 pd=2.58 ps=2.58 nrd=0.29 nrs=0.29 sa=0 sb=0 sd=0
+ mult=1
XM12 ib_5ua enb net4 vdd sky130_fd_pr__pfet_01v8_lvt L=0.35 W=1 nf=2 ad=0.145 as=0.29 pd=1.58 ps=3.16 nrd=0.29 nrs=0.29 sa=0 sb=0
+ sd=0 mult=1
x1 vdd en enb vss inv
XCC net3 vout sky130_fd_pr__cap_mim_m3_2 W=10 L=10 MF=1
.ends

* expanding   symbol:  /home/guru/Projects/sky130_opamp/xschem/inv/inv.sym # of pins=4
** sym_path: /home/guru/Projects/sky130_opamp/xschem/inv/inv.sym
** sch_path: /home/guru/Projects/sky130_opamp/xschem/inv/inv.sch
.subckt inv vdd x y vss
*.ipin vdd
*.ipin vss
*.ipin x
*.opin y
XM1 y x vdd vdd sky130_fd_pr__pfet_01v8_lvt L=0.5 W=1.2 nf=1 ad=0.348 as=0.348 pd=2.98 ps=2.98 nrd=0.241666666666667
+ nrs=0.241666666666667 sa=0 sb=0 sd=0 mult=1
XM2 y x vss vss sky130_fd_pr__nfet_01v8_lvt L=0.5 W=0.5 nf=1 ad=0.145 as=0.145 pd=1.58 ps=1.58 nrd=0.58 nrs=0.58 sa=0 sb=0 sd=0
+ mult=1
.ends

.end
