** sch_path: /home/guru/Projects/sky130_opamp/xschem/opamp/opamp.sch
.subckt opamp vdd vss vout vp vm ib_5ua en
*.PININFO vdd:I vss:I vm:I vp:I ib_5ua:I vout:O en:I
XM1 net2 vm net1 vdd sky130_fd_pr__pfet_01v8_lvt L=0.35 W=1 nf=1 ad=0.29 as=0.29 pd=2.58 ps=2.58 nrd=0.29 nrs=0.29 sa=0 sb=0 sd=0
+ mult=1
XM2 net3 vp net1 vdd sky130_fd_pr__pfet_01v8_lvt L=0.35 W=1 nf=1 ad=0.29 as=0.29 pd=2.58 ps=2.58 nrd=0.29 nrs=0.29 sa=0 sb=0 sd=0
+ mult=1
XM3 net2 net2 vss vss sky130_fd_pr__nfet_01v8_lvt L=0.15 W=1 nf=1 ad=0.29 as=0.29 pd=2.58 ps=2.58 nrd=0.29 nrs=0.29 sa=0 sb=0 sd=0
+ mult=1
XM4 net3 net2 vss vss sky130_fd_pr__nfet_01v8_lvt L=0.15 W=1 nf=1 ad=0.29 as=0.29 pd=2.58 ps=2.58 nrd=0.29 nrs=0.29 sa=0 sb=0 sd=0
+ mult=1
XM5 net1 net4 vdd vdd sky130_fd_pr__pfet_01v8_lvt L=0.35 W=1 nf=1 ad=0.29 as=0.29 pd=2.58 ps=2.58 nrd=0.29 nrs=0.29 sa=0 sb=0 sd=0
+ mult=1
XM6 vout net3 vss vss sky130_fd_pr__nfet_01v8_lvt L=0.15 W=1 nf=1 ad=0.29 as=0.29 pd=2.58 ps=2.58 nrd=0.29 nrs=0.29 sa=0 sb=0 sd=0
+ mult=1
XM7 vout net4 vdd vdd sky130_fd_pr__pfet_01v8_lvt L=0.35 W=1 nf=1 ad=0.29 as=0.29 pd=2.58 ps=2.58 nrd=0.29 nrs=0.29 sa=0 sb=0 sd=0
+ mult=1
XM8 net5 net4 vdd vdd sky130_fd_pr__pfet_01v8_lvt L=0.35 W=1 nf=1 ad=0.29 as=0.29 pd=2.58 ps=2.58 nrd=0.29 nrs=0.29 sa=0 sb=0 sd=0
+ mult=1
XM9 net4 en vdd vdd sky130_fd_pr__pfet_01v8_lvt L=0.35 W=1 nf=1 ad=0.29 as=0.29 pd=2.58 ps=2.58 nrd=0.29 nrs=0.29 sa=0 sb=0 sd=0
+ mult=1
XM10 net2 enb vss vss sky130_fd_pr__nfet_01v8_lvt L=0.15 W=1 nf=1 ad=0.29 as=0.29 pd=2.58 ps=2.58 nrd=0.29 nrs=0.29 sa=0 sb=0 sd=0
+ mult=1
XM11 net3 enb vss vss sky130_fd_pr__nfet_01v8_lvt L=0.15 W=1 nf=1 ad=0.29 as=0.29 pd=2.58 ps=2.58 nrd=0.29 nrs=0.29 sa=0 sb=0 sd=0
+ mult=1
XM12 ib_5ua enb net5 vdd sky130_fd_pr__pfet_01v8_lvt L=0.35 W=1 nf=1 ad=0.29 as=0.29 pd=2.58 ps=2.58 nrd=0.29 nrs=0.29 sa=0 sb=0
+ sd=0 mult=1
x1 vdd en enb vss inv
XC1 net3 vout sky130_fd_pr__cap_mim_m3_2 W=10 L=10 MF=1
.ends

* expanding   symbol:  /home/guru/Projects/sky130_opamp/xschem/inv/inv.sym # of pins=4
** sym_path: /home/guru/Projects/sky130_opamp/xschem/inv/inv.sym
** sch_path: /home/guru/Projects/sky130_opamp/xschem/inv/inv.sch
.subckt inv vdd x y vss
*.PININFO vdd:I vss:I x:I y:O
XM1 y x vdd vdd sky130_fd_pr__pfet_01v8_lvt L=0.5 W=1.2 nf=1 ad=0.348 as=0.348 pd=2.98 ps=2.98 nrd=0.241666666666667
+ nrs=0.241666666666667 sa=0 sb=0 sd=0 mult=1
XM2 y x vss vss sky130_fd_pr__nfet_01v8_lvt L=0.5 W=0.5 nf=1 ad=0.145 as=0.145 pd=1.58 ps=1.58 nrd=0.58 nrs=0.58 sa=0 sb=0 sd=0
+ mult=1
.ends
